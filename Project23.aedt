# Ansys Electronics Desktop project, version 2024.2
materials:
  vacuum: permittivity=1
  copper: permeability=0.999991 conductivity=58000000
  ferrite: core_loss_curve{100kHz (0, 0) (0.01, 72) (0.02, 477) (0.03, 1437) (0.04, 3143) (0.05, 5767) (0.06, 9469) (0.07, 14402) (0.08, 20710) (0.09, 28531) (0.1, 38000) (0.11, 49247) (0.12, 62398) (0.13, 77576) (0.14, 94902) (0.15, 114493) (0.16, 136466) (0.17, 160932) (0.18, 188004) (0.19, 217790) (0.2, 250400) (0.21, 285938) (0.22, 324510) (0.23, 366220) (0.24, 411168) (0.25, 459457) (0.26, 511185) (0.27, 566451) (0.28, 625354) (0.29, 687988) (0.3, 754450) (0.31, 824834) (0.32, 899235) (0.33, 977744) (0.34, 1060454) (0.35, 1147457) (0.36, 1238843) (0.37, 1334701) (0.38, 1435121) (0.39, 1540192) (0.4, 1650000)} core_loss_curve{200kHz (0, 0) (0.01, 387) (0.02, 2303) (0.03, 6540) (0.04, 13713) (0.05, 24354) (0.06, 38938) (0.07, 57900) (0.08, 81647) (0.09, 110560) (0.1, 145000) (0.11, 185313) (0.12, 231828) (0.13, 284864) (0.14, 344727) (0.15, 411714) (0.16, 486112) (0.17, 568202) (0.18, 658255) (0.19, 756537) (0.2, 863308) (0.21, 978820) (0.22, 1103324) (0.23, 1237061) (0.24, 1380270) (0.25, 1533185) (0.26, 1696037) (0.27, 1869052) (0.28, 2052452) (0.29, 2246457) (0.3, 2451281) (0.31, 2667138) (0.32, 2894237) (0.33, 3132784) (0.34, 3382985) (0.35, 3645039) (0.36, 3919146) (0.37, 4205503) (0.38, 4504304) (0.39, 4815739) (0.4, 5140000)} core_loss_curve{300kHz (0, 0) (0.01, 1300) (0.02, 7031) (0.03, 18872) (0.04, 38024) (0.05, 65470) (0.06, 102062) (0.07, 148555) (0.08, 205640) (0.09, 273951) (0.1, 354078) (0.11, 446577) (0.12, 551972) (0.13, 670762) (0.14, 803421) (0.15, 950404) (0.16, 1112148) (0.17, 1289073) (0.18, 1481586) (0.19, 1690079) (0.2, 1914933) (0.21, 2156516) (0.22, 2415189) (0.23, 2691301) (0.24, 2985191) (0.25, 3297194) (0.26, 3627633) (0.27, 3976825) (0.28, 4345082) (0.29, 4732708) (0.3, 5140000) (0.31, 5567251) (0.32, 6014748) (0.33, 6482772) (0.34, 6971600) (0.35, 7481505) (0.36, 8012753) (0.37, 8565608) (0.38, 9140330) (0.39, 9737173) (0.4, 10356389)} core_loss_curve{500kHz (0, 0) (0.01, 5400) (0.02, 25358) (0.03, 62667) (0.04, 119077) (0.05, 195917) (0.06, 294277) (0.07, 415088) (0.08, 559169) (0.09, 727252) (0.1, 920000) (0.11, 1138023) (0.12, 1381887) (0.13, 1652115) (0.14, 1949203) (0.15, 2273614) (0.16, 2625790) (0.17, 3006147) (0.18, 3415084) (0.19, 3852982) (0.2, 4320205) (0.21, 4817104) (0.22, 5344016) (0.23, 5901266) (0.24, 6489167) (0.25, 7108023) (0.26, 7758127) (0.27, 8439765) (0.28, 9153214) (0.29, 9898741) (0.3, 10676610) (0.31, 11487073) (0.32, 12330381) (0.33, 13206774) (0.34, 14116490) (0.35, 15059759) (0.36, 16036808) (0.37, 17047857) (0.38, 18093122) (0.39, 19172815) (0.4, 20287144)} core_loss_curve{1MHz (0, 0) (0.01, 29000) (0.02, 113627) (0.03, 252587) (0.04, 445207) (0.05, 691021) (0.06, 989674) (0.07, 1340877) (0.08, 1744389) (0.09, 2200000) (0.1, 2707528) (0.11, 3266809) (0.12, 3877697) (0.13, 4540057) (0.14, 5253766) (0.15, 6018712) (0.16, 6834788) (0.17, 7701896) (0.18, 8619944) (0.19, 9588845) (0.2, 10608518) (0.21, 11678883) (0.22, 12799869) (0.23, 13971404) (0.24, 15193422) (0.25, 16465858) (0.26, 17788652) (0.27, 19161743) (0.28, 20585077) (0.29, 22058597) (0.3, 23582252) (0.31, 25155992) (0.32, 26779766) (0.33, 28453527) (0.34, 30177231) (0.35, 31950832) (0.36, 33774287) (0.37, 35647555) (0.38, 37570594) (0.39, 39543365) (0.4, 41565830)} permittivity=12 permeability=3300 conductivity=0.01 core_loss_type="Power Ferrite" core_loss_cm=0.028945635 core_loss_x=1.7217855 core_loss_y=2.3862308 mass_density=4600 core_loss_equiv_cut_depth=0.001meter
  Al2_O3_ceramic: permittivity=9.8
  aluminum: permeability=1.000021 conductivity=38000000
  Ferrite_DMR95: core_loss_curve{100000Hz } core_loss_curve{200000Hz } core_loss_curve{300000Hz } core_loss_curve{500000Hz } core_loss_curve{1000000Hz } permittivity=1 permeability=3300 conductivity=0.1 core_loss_type="Power Ferrite" core_loss_cm=0.028945635 core_loss_x=1.7217855 core_loss_y=2.3862308 core_loss_equiv_cut_depth=1mm
  air: permittivity=1.0006 permeability=1.0000004

design Maxwell3DDesign1 (Maxwell 3D, EddyCurrent, model units mm)
geometry:
  P_coil [copper] = imported_body(D:\11kWnew\coil.STEP)
  P_coil.rotate(axis=X, angle=90deg)
  P_coil.move(25mm, -20mm, 6mm)
  ttpkp_attribute46_Section1 = P_coil.section(plane=YZ)
  ttpkp_attribute46_Section1_Separate16 [copper] = ttpkp_attribute46_Section1.separate_bodies()
  ttpkp_attribute46_Section1.delete()
  S_coil [copper] = imported_body(D:\11kWnew\coil_S.STEP)
  S_coil.rotate(axis=X, angle=90deg)
  S_coil.move(-7mm, 0mm, 140mm)
  S_core [ferrite] = box(corner=(-167mm, -167mm, 146mm), size=(334mm, 334mm, 5mm))
  S_Sheilding [aluminum] = box(corner=(-175mm, -175mm, 153mm), size=(350mm, 350mm, 8mm))
  ttpkp_attribute42_Section1 = S_coil.section(plane=YZ)
  ttpkp_attribute42_Section1_Separate23 [copper] = ttpkp_attribute42_Section1.separate_bodies()
  ttpkp_attribute42_Section1.delete()
  [P_coil, ttpkp_attribute46_Section1_Separate16].mirror(point=(0mm, 0mm, 0mm), normal=(0mm, 0mm, -1mm))
  P_Sheilding [aluminum] = box(corner=(-375mm, -300mm, -50mm), size=(750mm, 600mm, 3mm))
  [P_coil, ttpkp_attribute46_Section1_Separate16, P_Sheilding].move(0mm, 0mm, 50mm)
  Region [air] = region(percentage_offset=100 on all sides)
  [S_coil, S_core, S_Sheilding, ttpkp_attribute42_Section1_Separate23].move(0mm, 0mm, 70mm)
boundaries and excitations:
  CoilTerminal1: Coil Terminal Objects=ttpkp_attribute46_Section1_Separate16 Conductor_number=1 Winding=-1 Point_out_of_terminal=false
  CoilTerminal2: Coil Terminal Objects=ttpkp_attribute42_Section1_Separate23 Conductor_number=1 Winding=-1 Point_out_of_terminal=false
  core loss on: S_core
mesh:
  Length1: LengthBased Objects=P_coil NumMaxElem=60000 MaxLength=2.5mm
  Length2: LengthBased Objects=S_coil NumMaxElem=15000 MaxLength=2.5mm
  SkinDepth1: SkinDepthBased Objects=P_Sheilding NumMaxElem=70000 SkinDepth=0.28003628mm SurfTriMaxLength=20mm NumLayers=3
  SkinDepth2: SkinDepthBased Objects=S_Sheilding NumMaxElem=30000 SkinDepth=0.28003628mm SurfTriMaxLength=20mm NumLayers=3
  initial mesh: GlobalSurfApproximation{CurvedSurfaceApproxChoice=UseSlider SliderMeshSettings=9} GlobalCurvilinear{Apply} MeshMethod=AnsoftClassic
setups:
  Setup1: EddyCurrent MaximumPasses=13 MinimumPasses=2 MinimumConvergedPasses=1 PercentRefinement=30 PercentError=1 NonLinearResidual=0.0001 Frequency=85kHz LossAdaptiveCtrl=0.5
field calculator expressions:
  P_coil_H2 = Fundamental_Quantity(41) | Mag | 2 | Pow | EnterVolume(P_coil) | VolumeValue | Integrate
  S_coil_H2 = Fundamental_Quantity(41) | Mag | 2 | Pow | EnterVolume(S_coil) | VolumeValue | Integrate
